* ========================================================================
* FluxCore SPICE Testbench: brent_kung_8b (mitll_sfq5ee)
* Simulates 50 GHz SFQ Clock, Bias Rails, Calibrated Stimuli & Load Terminations
* ========================================================================
* Superconducting SPICE Netlist Generated by Superconducting Logic Synthesis (C++20 Engine)
* Circuit: top
* Target PDK: mitll_sfq5ee
* Gates: 45 | Splitters: 17 | DFFs: 64 | Total JJs: 612
* Logic Depth (GLP Clock Cycles): 17
* Total Estimated Area: 164500.0 um^2
************************************************************************

.param Tclk=20.0p
.tran 0.25p 500.0p 0 0.25p

* Cell Library Macro Definitions
.include mitll_sfq5ee_cells.inc

* Clock Distribution Rail
Vclk CLK 0 pulse(0 2m 5p 2p 2p 2p 20.0p)

* Primary Input Signal Sources
* PI: carries[0]
V_carries[0] n_0 0 pulse(0 2m 10.0p 2p 2p 2p 40.0p)

* Superconducting Gate-Level Pipelined Instances
X_3_g_0_ n_1 n_2 CLK n_3 AND2T
X_6_p_0_ n_4 n_5 CLK n_6 XORT
X_9_g_1_ n_7 n_8 CLK n_9 AND2T
X_12_p_1_ n_10 n_11 CLK n_12 XORT
X_15_g_2_ n_13 n_14 CLK n_15 AND2T
X_18_p_2_ n_16 n_17 CLK n_18 XORT
X_21_g_3_ n_19 n_20 CLK n_21 AND2T
X_24_p_3_ n_22 n_23 CLK n_24 XORT
X_27_g_4_ n_25 n_26 CLK n_27 AND2T
X_30_p_4_ n_28 n_29 CLK n_30 XORT
X_33_g_5_ n_31 n_32 CLK n_33 AND2T
X_36_p_5_ n_34 n_35 CLK n_36 XORT
X_39_g_6_ n_37 n_38 CLK n_39 AND2T
X_42_p_6_ n_40 n_41 CLK n_42 XORT
X_45_g_7_ n_43 n_44 CLK n_45 AND2T
X_48_p_7_ n_46 n_47 CLK n_48 XORT
X_50_node_50 n_49 n_86 CLK n_50 AND2T
X_51_carries_1_ n_50 n_102 CLK n_51 OR2T
X_52_node_52 n_87 n_94 CLK n_52 AND2T
X_53_carries_2_ n_52 n_105 CLK n_53 OR2T
X_54_node_54 n_88 n_95 CLK n_54 AND2T
X_55_carries_3_ n_54 n_110 CLK n_55 OR2T
X_56_node_56 n_89 n_96 CLK n_56 AND2T
X_57_carries_4_ n_56 n_117 CLK n_57 OR2T
X_58_node_58 n_90 n_97 CLK n_58 AND2T
X_59_carries_5_ n_58 n_126 CLK n_59 OR2T
X_60_node_60 n_91 n_98 CLK n_60 AND2T
X_61_carries_6_ n_60 n_137 CLK n_61 OR2T
X_62_node_62 n_92 n_99 CLK n_62 AND2T
X_63_carries_7_ n_62 n_150 CLK n_63 OR2T
X_64_node_64 n_93 n_100 CLK n_64 AND2T
X_65_cout n_64 n_165 CLK n_65 OR2T
X_67_sum_0_ n_66 n_86 CLK n_67 XORT
X_68_sum_1_ n_87 n_94 CLK n_68 XORT
X_69_sum_2_ n_88 n_95 CLK n_69 XORT
X_70_sum_3_ n_89 n_96 CLK n_70 XORT
X_71_sum_4_ n_90 n_97 CLK n_71 XORT
X_72_sum_5_ n_91 n_98 CLK n_72 XORT
X_73_sum_6_ n_92 n_99 CLK n_73 XORT
X_74_sum_7_ n_93 n_100 CLK n_74 XORT
X_77_g_0_ n_75 n_76 CLK n_77 AND2T
X_80_p_0_ n_78 n_79 CLK n_80 XORT
X_81_node_81 n_85 n_101 CLK n_81 AND2T
X_82_carries_1_ n_77 n_81 CLK n_82 OR2T
X_83_sum_0_ n_85 n_101 CLK n_83 XORT
X_85_split_0_0_2 n_0 n_81 n_83 SPLIT
X_86_split_6_0_2 n_6 n_50 n_67 SPLIT
X_87_split_12_0_2 n_12 n_52 n_68 SPLIT
X_88_split_18_0_2 n_18 n_54 n_69 SPLIT
X_89_split_24_0_2 n_24 n_56 n_70 SPLIT
X_90_split_30_0_2 n_30 n_58 n_71 SPLIT
X_91_split_36_0_2 n_36 n_60 n_72 SPLIT
X_92_split_42_0_2 n_42 n_62 n_73 SPLIT
X_93_split_48_0_2 n_48 n_64 n_74 SPLIT
X_94_split_51_0_2 n_51 n_52 n_68 SPLIT
X_95_split_53_0_2 n_53 n_54 n_69 SPLIT
X_96_split_55_0_2 n_55 n_56 n_70 SPLIT
X_97_split_57_0_2 n_57 n_58 n_71 SPLIT
X_98_split_59_0_2 n_59 n_60 n_72 SPLIT
X_99_split_61_0_2 n_61 n_62 n_73 SPLIT
X_100_split_63_0_2 n_63 n_64 n_74 SPLIT
X_101_split_80_0_2 n_80 n_81 n_83 SPLIT
X_102_pbmap_dff_3_to_51_0 n_3 CLK n_102 DFFT
X_103_pbmap_dff_9_to_53_0 n_9 CLK n_103 DFFT
X_104_pbmap_dff_9_to_53_1 n_103 CLK n_104 DFFT
X_105_pbmap_dff_9_to_53_2 n_104 CLK n_105 DFFT
X_106_pbmap_dff_15_to_55_0 n_15 CLK n_106 DFFT
X_107_pbmap_dff_15_to_55_1 n_106 CLK n_107 DFFT
X_108_pbmap_dff_15_to_55_2 n_107 CLK n_108 DFFT
X_109_pbmap_dff_15_to_55_3 n_108 CLK n_109 DFFT
X_110_pbmap_dff_15_to_55_4 n_109 CLK n_110 DFFT
X_111_pbmap_dff_21_to_57_0 n_21 CLK n_111 DFFT
X_112_pbmap_dff_21_to_57_1 n_111 CLK n_112 DFFT
X_113_pbmap_dff_21_to_57_2 n_112 CLK n_113 DFFT
X_114_pbmap_dff_21_to_57_3 n_113 CLK n_114 DFFT
X_115_pbmap_dff_21_to_57_4 n_114 CLK n_115 DFFT
X_116_pbmap_dff_21_to_57_5 n_115 CLK n_116 DFFT
X_117_pbmap_dff_21_to_57_6 n_116 CLK n_117 DFFT
X_118_pbmap_dff_27_to_59_0 n_27 CLK n_118 DFFT
X_119_pbmap_dff_27_to_59_1 n_118 CLK n_119 DFFT
X_120_pbmap_dff_27_to_59_2 n_119 CLK n_120 DFFT
X_121_pbmap_dff_27_to_59_3 n_120 CLK n_121 DFFT
X_122_pbmap_dff_27_to_59_4 n_121 CLK n_122 DFFT
X_123_pbmap_dff_27_to_59_5 n_122 CLK n_123 DFFT
X_124_pbmap_dff_27_to_59_6 n_123 CLK n_124 DFFT
X_125_pbmap_dff_27_to_59_7 n_124 CLK n_125 DFFT
X_126_pbmap_dff_27_to_59_8 n_125 CLK n_126 DFFT
X_127_pbmap_dff_33_to_61_0 n_33 CLK n_127 DFFT
X_128_pbmap_dff_33_to_61_1 n_127 CLK n_128 DFFT
X_129_pbmap_dff_33_to_61_2 n_128 CLK n_129 DFFT
X_130_pbmap_dff_33_to_61_3 n_129 CLK n_130 DFFT
X_131_pbmap_dff_33_to_61_4 n_130 CLK n_131 DFFT
X_132_pbmap_dff_33_to_61_5 n_131 CLK n_132 DFFT
X_133_pbmap_dff_33_to_61_6 n_132 CLK n_133 DFFT
X_134_pbmap_dff_33_to_61_7 n_133 CLK n_134 DFFT
X_135_pbmap_dff_33_to_61_8 n_134 CLK n_135 DFFT
X_136_pbmap_dff_33_to_61_9 n_135 CLK n_136 DFFT
X_137_pbmap_dff_33_to_61_10 n_136 CLK n_137 DFFT
X_138_pbmap_dff_39_to_63_0 n_39 CLK n_138 DFFT
X_139_pbmap_dff_39_to_63_1 n_138 CLK n_139 DFFT
X_140_pbmap_dff_39_to_63_2 n_139 CLK n_140 DFFT
X_141_pbmap_dff_39_to_63_3 n_140 CLK n_141 DFFT
X_142_pbmap_dff_39_to_63_4 n_141 CLK n_142 DFFT
X_143_pbmap_dff_39_to_63_5 n_142 CLK n_143 DFFT
X_144_pbmap_dff_39_to_63_6 n_143 CLK n_144 DFFT
X_145_pbmap_dff_39_to_63_7 n_144 CLK n_145 DFFT
X_146_pbmap_dff_39_to_63_8 n_145 CLK n_146 DFFT
X_147_pbmap_dff_39_to_63_9 n_146 CLK n_147 DFFT
X_148_pbmap_dff_39_to_63_10 n_147 CLK n_148 DFFT
X_149_pbmap_dff_39_to_63_11 n_148 CLK n_149 DFFT
X_150_pbmap_dff_39_to_63_12 n_149 CLK n_150 DFFT
X_151_pbmap_dff_45_to_65_0 n_45 CLK n_151 DFFT
X_152_pbmap_dff_45_to_65_1 n_151 CLK n_152 DFFT
X_153_pbmap_dff_45_to_65_2 n_152 CLK n_153 DFFT
X_154_pbmap_dff_45_to_65_3 n_153 CLK n_154 DFFT
X_155_pbmap_dff_45_to_65_4 n_154 CLK n_155 DFFT
X_156_pbmap_dff_45_to_65_5 n_155 CLK n_156 DFFT
X_157_pbmap_dff_45_to_65_6 n_156 CLK n_157 DFFT
X_158_pbmap_dff_45_to_65_7 n_157 CLK n_158 DFFT
X_159_pbmap_dff_45_to_65_8 n_158 CLK n_159 DFFT
X_160_pbmap_dff_45_to_65_9 n_159 CLK n_160 DFFT
X_161_pbmap_dff_45_to_65_10 n_160 CLK n_161 DFFT
X_162_pbmap_dff_45_to_65_11 n_161 CLK n_162 DFFT
X_163_pbmap_dff_45_to_65_12 n_162 CLK n_163 DFFT
X_164_pbmap_dff_45_to_65_13 n_163 CLK n_164 DFFT
X_165_pbmap_dff_45_to_65_14 n_164 CLK n_165 DFFT

* Primary Output Terminations
* PO: cout
R_load_84 n_65 0 10.0
.plot v(CLK) v(n_0) v(n_65)
.end
