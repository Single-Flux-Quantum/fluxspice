* ========================================================================
* FluxCore SPICE Testbench: shift_register_left (mitll_sfq5ee)
* Simulates 50 GHz SFQ Clock, Bias Rails, Calibrated Stimuli & Load Terminations
* ========================================================================
* Superconducting SPICE Netlist Generated by Superconducting Logic Synthesis (C++20 Engine)
* Circuit: top
* Target PDK: mitll_sfq5ee
* Gates: 0 | Splitters: 0 | DFFs: 3 | Total JJs: 12
* Logic Depth (GLP Clock Cycles): 1
* Total Estimated Area: 4200.0 um^2
************************************************************************

.param Tclk=20.0p
.tran 0.25p 500.0p 0 0.25p

* Cell Library Macro Definitions
.include mitll_sfq5ee_cells.inc

* Clock Distribution Rail
Vclk CLK 0 pulse(0 2m 5p 2p 2p 2p 20.0p)

* Primary Input Signal Sources
* PI: clk
V_clk n_0 0 pulse(0 2m 10.0p 2p 2p 2p 40.0p)
* PI: rst_n
V_rst_n n_1 0 pulse(0 2m 10.5p 2p 2p 2p 40.0p)
* PI: en
V_en n_2 0 pulse(0 2m 11.0p 2p 2p 2p 40.0p)
* PI: load
V_load n_3 0 pulse(0 2m 11.5p 2p 2p 2p 40.0p)
* PI: serial_in
V_serial_in n_4 0 pulse(0 2m 12.0p 2p 2p 2p 40.0p)

* Superconducting Gate-Level Pipelined Instances
X_8_parallel_out n_7 CLK n_8 DFFT
X_10_parallel_out n_9 CLK n_10 DFFT
X_12_parallel_out n_11 CLK n_12 DFFT

* Primary Output Terminations
* PO: serial_out
R_load_13 n_6 0 10.0

.end
