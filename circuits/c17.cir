* ========================================================================
* FluxCore SPICE Testbench: c17 (mitll_sfq5ee)
* Simulates 50 GHz SFQ Clock, Bias Rails, Calibrated Stimuli & Load Terminations
* ========================================================================
* Superconducting SPICE Netlist Generated by Superconducting Logic Synthesis (C++20 Engine)
* Circuit: top
* Target PDK: mitll_sfq5ee
* Gates: 12 | Splitters: 3 | DFFs: 6 | Total JJs: 102
* Logic Depth (GLP Clock Cycles): 6
* Total Estimated Area: 27300.0 um^2
************************************************************************

.param Tclk=20.0p
.tran 0.25p 500.0p 0 0.25p

* Cell Library Macro Definitions
.include mitll_sfq5ee_cells.inc

* Clock Distribution Rail
Vclk CLK 0 pulse(0 2m 5p 2p 2p 2p 20.0p)

* Primary Input Signal Sources
* PI: N1
V_N1 n_0 0 pulse(0 2m 10.0p 2p 2p 2p 40.0p)
* PI: N2
V_N2 n_1 0 pulse(0 2m 10.5p 2p 2p 2p 40.0p)
* PI: N3
V_N3 n_2 0 pulse(0 2m 11.0p 2p 2p 2p 40.0p)
* PI: N6
V_N6 n_3 0 pulse(0 2m 11.5p 2p 2p 2p 40.0p)
* PI: N7
V_N7 n_4 0 pulse(0 2m 12.0p 2p 2p 2p 40.0p)

* Superconducting Gate-Level Pipelined Instances
X_5_node_5 n_0 n_19 CLK n_5 AND2T
X_6_N10 n_5 CLK n_6 NOTT
X_7_node_7 n_3 n_19 CLK n_7 AND2T
X_8_N11 n_7 CLK n_8 NOTT
X_9_node_9 n_20 n_23 CLK n_9 AND2T
X_10_N16 n_9 CLK n_10 NOTT
X_11_node_11 n_20 n_25 CLK n_11 AND2T
X_12_N19 n_11 CLK n_12 NOTT
X_13_node_13 n_21 n_27 CLK n_13 AND2T
X_14_N22 n_13 CLK n_14 NOTT
X_15_node_15 n_12 n_21 CLK n_15 AND2T
X_16_N23 n_15 CLK n_16 NOTT
X_19_split_2_0 n_2 n_5 n_7 SPLIT
X_20_split_8_0 n_8 n_9 n_11 SPLIT
X_21_split_10_0 n_10 n_13 n_15 SPLIT
X_22_pbmap_dff_1_to_9_0 n_1 CLK n_22 DFFT
X_23_pbmap_dff_1_to_9_1 n_22 CLK n_23 DFFT
X_24_pbmap_dff_4_to_11_0 n_4 CLK n_24 DFFT
X_25_pbmap_dff_4_to_11_1 n_24 CLK n_25 DFFT
X_26_pbmap_dff_6_to_13_0 n_6 CLK n_26 DFFT
X_27_pbmap_dff_6_to_13_1 n_26 CLK n_27 DFFT

* Primary Output Terminations
* PO: N22
R_load_17 n_14 0 10.0
* PO: N23
R_load_18 n_16 0 10.0

.plot v(CLK) v(n_0) v(n_1) v(n_2) v(n_3) v(n_4) v(n_14) v(n_16)
.end
