* ========================================================================
* FluxCore SPICE Testbench: carry_lookahead_4b (mitll_sfq5ee)
* Simulates 50 GHz SFQ Clock, Bias Rails, Calibrated Stimuli & Load Terminations
* ========================================================================
* Superconducting SPICE Netlist Generated by Superconducting Logic Synthesis (C++20 Engine)
* Circuit: top
* Target PDK: mitll_sfq5ee
* Gates: 19 | Splitters: 0 | DFFs: 0 | Total JJs: 124
* Logic Depth (GLP Clock Cycles): 2
* Total Estimated Area: 26600.0 um^2
************************************************************************

.param Tclk=20.0p
.tran 0.25p 500.0p 0 0.25p

* Cell Library Macro Definitions
.include mitll_sfq5ee_cells.inc

* Clock Distribution Rail
Vclk CLK 0 pulse(0 2m 5p 2p 2p 2p 20.0p)

* Primary Input Signal Sources
* PI: c[0]
V_c[0] n_0 0 pulse(0 2m 10.0p 2p 2p 2p 40.0p)

* Superconducting Gate-Level Pipelined Instances
X_3_g_0_ n_1 n_2 CLK n_3 AND2T
X_6_p_0_ n_4 n_5 CLK n_6 XORT
X_9_g_1_ n_7 n_8 CLK n_9 AND2T
X_12_p_1_ n_10 n_11 CLK n_12 XORT
X_15_g_2_ n_13 n_14 CLK n_15 AND2T
X_18_p_2_ n_16 n_17 CLK n_18 XORT
X_21_g_3_ n_19 n_20 CLK n_21 AND2T
X_24_p_3_ n_22 n_23 CLK n_24 XORT
X_26_sum_0_ n_6 n_25 CLK n_26 XORT
X_28_sum_1_ n_12 n_27 CLK n_28 XORT
X_30_sum_2_ n_18 n_29 CLK n_30 XORT
X_32_sum_3_ n_24 n_31 CLK n_32 XORT
X_39_c_internal_1_ n_37 n_38 CLK n_39 OR2T
X_42_c_internal_2_ n_40 n_41 CLK n_42 OR2T
X_45_c_internal_3_ n_43 n_44 CLK n_45 OR2T
X_48_g_0_ n_46 n_47 CLK n_48 AND2T
X_51_p_0_ n_49 n_50 CLK n_51 XORT
X_53_sum_0_ n_51 n_52 CLK n_53 XORT
X_57_c_internal_0_ n_55 n_56 CLK n_57 OR2T

* Primary Output Terminations
* PO: cout
R_load_58 n_54 0 10.0

.end
