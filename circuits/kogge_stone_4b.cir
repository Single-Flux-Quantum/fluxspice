* ========================================================================
* FluxCore SPICE Testbench: kogge_stone_4b (mitll_sfq5ee)
* Simulates 50 GHz SFQ Clock, Bias Rails, Calibrated Stimuli & Load Terminations
* ========================================================================
* Superconducting SPICE Netlist Generated by Superconducting Logic Synthesis (C++20 Engine)
* Circuit: top
* Target PDK: mitll_sfq5ee
* Gates: 25 | Splitters: 4 | DFFs: 16 | Total JJs: 240
* Logic Depth (GLP Clock Cycles): 8
* Total Estimated Area: 60200.0 um^2
************************************************************************

.param Tclk=20.0p
.tran 0.25p 500.0p 0 0.25p

* Cell Library Macro Definitions
.include mitll_sfq5ee_cells.inc

* Clock Distribution Rail
Vclk CLK 0 pulse(0 2m 5p 2p 2p 2p 20.0p)

* Primary Input Signal Sources
* PI: carries[0]
V_carries[0] n_0 0 pulse(0 2m 10.0p 2p 2p 2p 40.0p)

* Superconducting Gate-Level Pipelined Instances
X_3_g_init_0_ n_1 n_2 CLK n_3 AND2T
X_6_p_init_0_ n_4 n_5 CLK n_6 XORT
X_9_g_init_1_ n_7 n_8 CLK n_9 AND2T
X_12_p_init_1_ n_10 n_11 CLK n_12 XORT
X_15_g_init_2_ n_13 n_14 CLK n_15 AND2T
X_18_p_init_2_ n_16 n_17 CLK n_18 XORT
X_21_g_init_3_ n_19 n_20 CLK n_21 AND2T
X_24_p_init_3_ n_22 n_23 CLK n_24 XORT
X_28_node_28 n_26 n_27 CLK n_28 AND2T
X_29_carries_1_ n_28 n_63 CLK n_29 OR2T
X_32_node_32 n_31 n_60 CLK n_32 AND2T
X_33_carries_2_ n_32 n_66 CLK n_33 OR2T
X_36_node_36 n_35 n_61 CLK n_36 AND2T
X_37_carries_3_ n_36 n_71 CLK n_37 OR2T
X_40_node_40 n_39 n_62 CLK n_40 AND2T
X_41_cout n_40 n_78 CLK n_41 OR2T
X_43_sum_0_ n_6 n_42 CLK n_43 XORT
X_44_sum_1_ n_12 n_60 CLK n_44 XORT
X_45_sum_2_ n_18 n_61 CLK n_45 XORT
X_46_sum_3_ n_24 n_62 CLK n_46 XORT
X_49_g_init_0_ n_47 n_48 CLK n_49 AND2T
X_52_p_init_0_ n_50 n_51 CLK n_52 XORT
X_55_node_55 n_54 n_59 CLK n_55 AND2T
X_56_carries_1_ n_53 n_55 CLK n_56 OR2T
X_57_sum_0_ n_52 n_59 CLK n_57 XORT
X_59_split_0_0_2 n_0 n_55 n_57 SPLIT
X_60_split_29_0_2 n_29 n_32 n_44 SPLIT
X_61_split_33_0_2 n_33 n_36 n_45 SPLIT
X_62_split_37_0_2 n_37 n_40 n_46 SPLIT
X_63_pbmap_dff_25_to_29_0 n_25 CLK n_63 DFFT
X_64_pbmap_dff_30_to_33_0 n_30 CLK n_64 DFFT
X_65_pbmap_dff_30_to_33_1 n_64 CLK n_65 DFFT
X_66_pbmap_dff_30_to_33_2 n_65 CLK n_66 DFFT
X_67_pbmap_dff_34_to_37_0 n_34 CLK n_67 DFFT
X_68_pbmap_dff_34_to_37_1 n_67 CLK n_68 DFFT
X_69_pbmap_dff_34_to_37_2 n_68 CLK n_69 DFFT
X_70_pbmap_dff_34_to_37_3 n_69 CLK n_70 DFFT
X_71_pbmap_dff_34_to_37_4 n_70 CLK n_71 DFFT
X_72_pbmap_dff_38_to_41_0 n_38 CLK n_72 DFFT
X_73_pbmap_dff_38_to_41_1 n_72 CLK n_73 DFFT
X_74_pbmap_dff_38_to_41_2 n_73 CLK n_74 DFFT
X_75_pbmap_dff_38_to_41_3 n_74 CLK n_75 DFFT
X_76_pbmap_dff_38_to_41_4 n_75 CLK n_76 DFFT
X_77_pbmap_dff_38_to_41_5 n_76 CLK n_77 DFFT
X_78_pbmap_dff_38_to_41_6 n_77 CLK n_78 DFFT

* Primary Output Terminations
* PO: cout
R_load_58 n_41 0 10.0

.end
