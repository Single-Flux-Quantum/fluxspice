* ========================================================================
* FluxCore SPICE Testbench: brent_kung_4b (mitll_sfq5ee)
* Simulates 50 GHz SFQ Clock, Bias Rails, Calibrated Stimuli & Load Terminations
* ========================================================================
* Superconducting SPICE Netlist Generated by Superconducting Logic Synthesis (C++20 Engine)
* Circuit: top
* Target PDK: mitll_sfq5ee
* Gates: 25 | Splitters: 9 | DFFs: 16 | Total JJs: 260
* Logic Depth (GLP Clock Cycles): 9
* Total Estimated Area: 63700.0 um^2
************************************************************************

.param Tclk=20.0p
.tran 0.25p 500.0p 0 0.25p

* Cell Library Macro Definitions
.include mitll_sfq5ee_cells.inc

* Clock Distribution Rail
Vclk CLK 0 pulse(0 2m 5p 2p 2p 2p 20.0p)

* Primary Input Signal Sources
* PI: carries[0]
V_carries[0] n_0 0 pulse(0 2m 10.0p 2p 2p 2p 40.0p)

* Superconducting Gate-Level Pipelined Instances
X_3_g_0_ n_1 n_2 CLK n_3 AND2T
X_6_p_0_ n_4 n_5 CLK n_6 XORT
X_9_g_1_ n_7 n_8 CLK n_9 AND2T
X_12_p_1_ n_10 n_11 CLK n_12 XORT
X_15_g_2_ n_13 n_14 CLK n_15 AND2T
X_18_p_2_ n_16 n_17 CLK n_18 XORT
X_21_g_3_ n_19 n_20 CLK n_21 AND2T
X_24_p_3_ n_22 n_23 CLK n_24 XORT
X_26_node_26 n_25 n_50 CLK n_26 AND2T
X_27_carries_1_ n_26 n_58 CLK n_27 OR2T
X_28_node_28 n_51 n_54 CLK n_28 AND2T
X_29_carries_2_ n_28 n_61 CLK n_29 OR2T
X_30_node_30 n_52 n_55 CLK n_30 AND2T
X_31_carries_3_ n_30 n_66 CLK n_31 OR2T
X_32_node_32 n_53 n_56 CLK n_32 AND2T
X_33_cout n_32 n_73 CLK n_33 OR2T
X_35_sum_0_ n_34 n_50 CLK n_35 XORT
X_36_sum_1_ n_51 n_54 CLK n_36 XORT
X_37_sum_2_ n_52 n_55 CLK n_37 XORT
X_38_sum_3_ n_53 n_56 CLK n_38 XORT
X_41_g_0_ n_39 n_40 CLK n_41 AND2T
X_44_p_0_ n_42 n_43 CLK n_44 XORT
X_45_node_45 n_49 n_57 CLK n_45 AND2T
X_46_carries_1_ n_41 n_45 CLK n_46 OR2T
X_47_sum_0_ n_49 n_57 CLK n_47 XORT
X_49_split_0_0_2 n_0 n_45 n_47 SPLIT
X_50_split_6_0_2 n_6 n_26 n_35 SPLIT
X_51_split_12_0_2 n_12 n_28 n_36 SPLIT
X_52_split_18_0_2 n_18 n_30 n_37 SPLIT
X_53_split_24_0_2 n_24 n_32 n_38 SPLIT
X_54_split_27_0_2 n_27 n_28 n_36 SPLIT
X_55_split_29_0_2 n_29 n_30 n_37 SPLIT
X_56_split_31_0_2 n_31 n_32 n_38 SPLIT
X_57_split_44_0_2 n_44 n_45 n_47 SPLIT
X_58_pbmap_dff_3_to_27_0 n_3 CLK n_58 DFFT
X_59_pbmap_dff_9_to_29_0 n_9 CLK n_59 DFFT
X_60_pbmap_dff_9_to_29_1 n_59 CLK n_60 DFFT
X_61_pbmap_dff_9_to_29_2 n_60 CLK n_61 DFFT
X_62_pbmap_dff_15_to_31_0 n_15 CLK n_62 DFFT
X_63_pbmap_dff_15_to_31_1 n_62 CLK n_63 DFFT
X_64_pbmap_dff_15_to_31_2 n_63 CLK n_64 DFFT
X_65_pbmap_dff_15_to_31_3 n_64 CLK n_65 DFFT
X_66_pbmap_dff_15_to_31_4 n_65 CLK n_66 DFFT
X_67_pbmap_dff_21_to_33_0 n_21 CLK n_67 DFFT
X_68_pbmap_dff_21_to_33_1 n_67 CLK n_68 DFFT
X_69_pbmap_dff_21_to_33_2 n_68 CLK n_69 DFFT
X_70_pbmap_dff_21_to_33_3 n_69 CLK n_70 DFFT
X_71_pbmap_dff_21_to_33_4 n_70 CLK n_71 DFFT
X_72_pbmap_dff_21_to_33_5 n_71 CLK n_72 DFFT
X_73_pbmap_dff_21_to_33_6 n_72 CLK n_73 DFFT

* Primary Output Terminations
* PO: cout
R_load_48 n_33 0 10.0
.plot v(CLK) v(n_0) v(n_65)
.end
