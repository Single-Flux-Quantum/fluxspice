* ========================================================================
* FluxCore SPICE Testbench: gray_counter (mitll_sfq5ee)
* Simulates 50 GHz SFQ Clock, Bias Rails, Calibrated Stimuli & Load Terminations
* ========================================================================
* Superconducting SPICE Netlist Generated by Superconducting Logic Synthesis (C++20 Engine)
* Circuit: top
* Target PDK: mitll_sfq5ee
* Gates: 2 | Splitters: 1 | DFFs: 6 | Total JJs: 42
* Logic Depth (GLP Clock Cycles): 2
* Total Estimated Area: 11900.0 um^2
************************************************************************

.param Tclk=20.0p
.tran 0.25p 500.0p 0 0.25p

* Cell Library Macro Definitions
.include mitll_sfq5ee_cells.inc

* Clock Distribution Rail
Vclk CLK 0 pulse(0 2m 5p 2p 2p 2p 20.0p)

* Primary Input Signal Sources
* PI: clk
V_clk n_0 0 pulse(0 2m 10.0p 2p 2p 2p 40.0p)
* PI: rst_n
V_rst_n n_1 0 pulse(0 2m 10.5p 2p 2p 2p 40.0p)
* PI: enable
V_enable n_2 0 pulse(0 2m 11.0p 2p 2p 2p 40.0p)
* PI: next_binary
V_next_binary n_3 0 pulse(0 2m 11.5p 2p 2p 2p 40.0p)
* PI: load
V_load n_4 0 pulse(0 2m 12.0p 2p 2p 2p 40.0p)

* Superconducting Gate-Level Pipelined Instances
X_8_binary_count n_7 CLK n_8 DFFT
X_10_gray_out n_9 CLK n_10 DFFT
X_12_binary_count n_11 CLK n_12 DFFT
X_15_node_15 n_13 n_14 CLK n_15 XORT
X_16_gray_out n_15 CLK n_16 DFFT
X_17_binary_count n_20 CLK n_17 DFFT
X_18_node_18 n_20 0 CLK n_18 XORT
X_19_gray_out n_18 CLK n_19 DFFT
X_20_split_3_0 n_3 n_17 n_18 SPLIT

* Primary Output Terminations

.end
